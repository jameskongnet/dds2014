[IBIS Ver]   4.1
[Comment Char] |_char
[File Name]   system.ibs
[File Rev]   1.0
[Date]   November 16, 2013
[Source]   Derived from cycloneIII_spice_model,rev 1.0, dated 11/02/07
   using HSPICE Y-2006.03
[Notes]   - The models are designated as "Correlated" and have been
   correlated against physical device operation.
   - This IBIS model is checked using IBISCHK v4.2.2
   There are no known errors and warnings reported.
   - There are no known limitations for this IBIS model release.
   - Contact point: Altera Corporation,
   http://www.altera.com/corporate/contact/con-index.html
   - This file is generated using Quartus II
   Version 13.0.0 Build 156 04/24/2013 SJ Full Version
   - Unused IOs which have been assigned as tri-stated inputs or
   as outputs driving any signal in Quartus II are represented
   by the NC.
   - Only general purpose and configuration I/O IBIS models are
   supported
   Revision History
   - v1.0
   - Initial Release of Cyclone IV IBIS models
   - v2.0
   - Added configuration pins IBIS models
   - C_comp values for different pin types
   When an IBIS model is assigned to different pin types in
   Cyclone III LS devices, the C_comp value will be different.
   Use the following C_comp values according to the pin types:
   Pin Type   C_comp
   Normal Column I/O   4.7pF
   Normal Row I/O   4.4pF
   Differential Row I/O   5.0pF
   *Note (1): These IBIS models are generated based on a
   pre-determined Quartus II default slew rate setting.
   For IBIS models with other slew rate settings,
   please contact Altera Corporation.
[Disclaimer]   Data is for modeling purposes only and is not guaranteed.
[Copyright]   Copyright (C) 1991-2013 Altera Corporation
[Component]   EP4CGX30CF23C6_system
[Manufacturer] Altera Corporation
[Package]
| RLC values are for 484 FBGA package
| variable  typ   min   max
R_pkg   0.00m   NA   NA
L_pkg   1.00nH   NA   NA
C_pkg   1.00pF   NA   NA
[Pin]  signal_name   model_name   R_pin   L_pin   C_pin
A1   DFW[20]   ttl25_cin_p
A10   DOUT[6]   ttl25_cio_r50
A11   F1H[1]   ttl25_cin_p
A12   F2L[15]   ttl25_cin_p
A13   F1L[5]   ttl25_cin_p
A14   F2L[12]   ttl25_cin_p
A15   F1H[15]   ttl25_cin_p
A16   F1L[15]   ttl25_cin_p
A17   F1L[19]   ttl25_cin_p
A18   F2L[31]   ttl25_cin_p
A19   F1L[21]   ttl25_cin_p
A2   F2L[28]   ttl25_cin_p
A20   DFW[25]   ttl25_rdin_p
A21   F1L[31]   ttl25_rdin_p
A22   F2L[7]   ttl25_rdin_p
A3   DFW[41]   ttl25_cin_p
A4   DFW[19]   ttl25_cin_p
A5   F2H[2]   ttl25_cin_p
A6   F2H[1]   ttl25_cin_p
A7   F1H[5]   ttl25_cin_p
A8   DFW[34]   ttl25_cin_p
AA1   GND   GND
AA10   DFW[22]   ttl25_cin_p
AA11   GND   GND
AA12   F1H[13]   ttl25_cin_p
AA13   RAMPRATE[10]   ttl25_cin_p
AA14   GND   GND
AA15   RAMPRATE[6]   ttl25_cin_p
AA16   MODE[0]   ttl25_cin_p
AA17   GND   GND
AA18   DFW[46]   ttl25_cin_p
AA19   DFW[21]   ttl25_cin_p
AA2   GND   GND
AA20   F1L[4]   ttl25_cin_p
AA5   GND   GND
AA8   GND   GND
AB10   RAMPRATE[4]   ttl25_cin_p
AB11   DFW[43]   ttl25_cin_p
AB12   F2L[30]   ttl25_cin_p
AB13   DFW[9]   ttl25_cin_p
AB14   DFW[40]   ttl25_cin_p
AB15   DOUT[3]   ttl25_cio_r50
AB16   F2L[14]   ttl25_cin_p
AB17   F1L[27]   ttl25_cin_p
AB18   F1L[9]   ttl25_cin_p
AB19   DFW[39]   ttl25_cin_p
AB2   GND   GND
AB9   RAMPRATE[1]   ttl25_cin_p
B1   DFW[16]   ttl25_cin_p
B10   RAMPRATE[11]   ttl25_cin_p
B11   GND   GND
B12   MODE[2]   ttl25_cin_p
B13   CEN   ttl25_cin_p
B14   GND   GND
B15   RAMPRATE[13]   ttl25_cin_p
B16   F2L[10]   ttl25_cin_p
B17   GND   GND
B18   F1L[17]   ttl25_cin_p
B2   GND   GND
B20   RAMPRATE[16]   ttl25_rdin_p
B21   F2L[23]   ttl25_rdin_p
B22   DFW[47]   ttl25_rdin_p
B3   F2H[0]   ttl25_cin_p
B4   F2L[18]   ttl25_cin_p
B5   GND   GND
B6   F2L[21]   ttl25_cin_p
B7   F2H[10]   ttl25_cin_p
B8   GND   GND
C1   F2H[9]   ttl25_cin_p
C10   RAMPRATE[14]   ttl25_cin_p
C11   F2H[11]   ttl25_cin_p
C12   F1H[14]   ttl25_cin_p
C13   F2L[29]   ttl25_cin_p
C14   F1L[2]   ttl25_cin_p
C15   F1H[8]   ttl25_cin_p
C16   DFW[31]   ttl25_cin_p
C17   F2L[20]   ttl25_cin_p
C19   F1L[20]   ttl25_rdin_p
C2   F2L[6]   ttl25_cin_p
C20   RAMPRATE[7]   ttl25_rdin_p
C21   GND   GND
C22   F2H[7]   ttl25_rdin_p
C3   DOUT[0]   ttl25_cio_r50
C6   F2L[8]   ttl25_cin_p
C7   F2L[3]   ttl25_cin_p
C8   F2L[24]   ttl25_cin_p
D11   F1L[6]   ttl25_cin_p
D12   F1H[6]   ttl25_cin_p
D13   DFW[37]   ttl25_cin_p
D14   F2L[11]   ttl25_cin_p
D15   F1L[16]   ttl25_cin_p
D16   RAMPRATE[15]   ttl25_cin_p
D17   WRITE   ttl25_cio_r50
D18   GND   GND
D19   DFW[12]   ttl25_rdin_p
D20   F1L[28]   ttl25_rdin_p
D21   DFW[23]   ttl25_rdin_p
D22   AOUT[3]   ttl25_rdio_r50
D7   F1L[25]   ttl25_cin_p
D8   F2L[1]   ttl25_cin_p
E1   GND   GND
E10   VCCIO8   POWER
E11   VCCIO8   POWER
E12   VCCIO8   POWER
E13   VCCIO7   POWER
E14   VCCIO7   POWER
E15   VCCIO7   POWER
E16   VCCIO7   POWER
E17   F1L[22]   ttl25_cin_p
E18   VCCD_PLL   POWER
E2   GND   GND
E20   AOUT[2]   ttl25_rdio_r50
E21   DFW[15]   ttl25_rdin_p
E22   F2H[13]   ttl25_rdin_p
E3   TDO   2p5_o_tdo
E4   TCK   ttl33_rin
E7   GND   GND
E8   DOUT[4]   ttl25_cio_r50
E9   VCCIO8   POWER
F10   VCCIO8   POWER
F11   GND   GND
F12   F2L[4]   ttl25_cin_p
F13   GND   GND
F14   VCCIO7   POWER
F15   GND   GND
F16   F1L[29]   ttl25_cin_p
F17   F2H[5]   ttl25_cin_p
F19   VCCA   POWER
F20   F1H[0]   ttl25_rdin_p
F21   GND   GND
F22   F1H[2]   ttl25_rdin_p
F4   VCCA   POWER
F5   TDI   ttl33_rin
F7   VCCINT   POWER
F8   DFW[32]   ttl25_cin_p
F9   GND   GND
G1   GND   GND
G12   DFW[26]   ttl25_cin_p
G13   VCCINT   POWER
G14   F2H[3]   ttl25_cin_p
G15   F1L[0]   ttl25_cin_p
G2   GND   GND
G20   F1L[3]   ttl25_rdin_p
G21   AOUT[0]   ttl25_rdio_r50
G22   DFW[7]   ttl25_rdin_p
G3   VCCD_PLL   POWER
G4   VCCIO9   POWER
G5   TMS   ttl33_rin
G9   VCCINT   POWER
H10   VCC_CLKIN8A   POWER
H11   GND   GND
H12   DFW[24]   ttl25_cin_p
H13   F2L[0]   ttl25_cin_p
H14   F2L[27]   ttl25_cin_p
H17   F2H[15]   ttl25_rin_p
H18   GND   GND
H19   VCCIO6   POWER
H20   F1L[30]   ttl25_rdin_p
H21   RAMPRATE[8]   ttl25_rdin_p
H22   AOUT[4]   ttl25_rdio_r50
H3   VCCH_GXB   POWER
H5   GND   GND
H6   VCCINT   POWER
J1   GND   GND
J11   VCCINT   POWER
J12   DOUT[1]   ttl25_cio_r50
J13   DFW[44]   ttl25_cin_p
J14   F2H[14]   ttl25_cin_p
J15   MODE[1]   ttl25_rin_p
J17   VCCINT   POWER
J18   VCCIO6   POWER
J19   DFW[33]   ttl25_rdin_p
J2   GND   GND
J20   F1L[8]   ttl25_rdin_p
J21   RESET   ttl25_rdio_r50
J22   F2L[5]   ttl25_rdin_p
J3   VCCA_GXB   POWER
J5   VCCINT   POWER
J6   GND   GND
J7   VCCINT   POWER
J8   GND   GND
J9   VCCINT   POWER
K11   GND   GND
K12   F2L[2]   ttl25_cin_p
K15   GND   GND
K16   VCCINT   POWER
K18   VCCIO6   POWER
K19   F1H[10]   ttl25_rdin_p
K20   DOUT[7]   ttl25_rdio_r50
K21   GND   GND
K22   AOUT[1]   ttl25_rdio_r50
K3   VCCL_GXB   POWER
K5   GND   GND
K6   VCCINT   POWER
K7   GND   GND
K8   VCCINT   POWER
K9   GND   GND
L1   GND   GND
L10   GND   GND
L11   VCCINT   POWER
L12   GND   GND
L13   F1L[14]   ttl25_rdin_p
L14   F2L[9]   ttl25_rdin_p
L15   DFW[38]   ttl25_rdin_p
L16   RAMPRATE[9]   ttl25_rdin_p
L17   VCCINT   POWER
L18   GND   GND
L19   F2L[22]   ttl25_rdin_p
L2   GND   GND
L20   F2H[8]   ttl25_rdin_p
L21   DFW[13]   ttl25_rdin_p
L22   RAMPRATE[5]   ttl25_rdin_p
L3   VCCL_GXB   POWER
L4   VCCA   POWER
L5   VCCINT   POWER
L6   GND   GND
L7   VCCINT   POWER
L8   GND   GND
L9   VCCINT   POWER
M10   VCCINT   POWER
M12   VCCINT   POWER
M13   F1H[9]   ttl25_rdin_p
M14   F1L[7]   ttl25_rdin_p
M15   F1L[23]   ttl25_rdin_p
M16   F2L[17]   ttl25_rdin_p
M17   DFW[18]   ttl25_rdin_p
M18   DFW[45]   ttl25_rdin_p
M19   RAMPRATE[17]   ttl25_rdin_p
M20   RAMPRATE[18]   ttl25_rin_p
M21   DFW[36]   ttl25_rdin_p
M22   DFW[4]   ttl25_rdin_p
M4   VCCD_PLL   POWER
M5   GND   GND
M6   VCCINT   POWER
M9   GND   GND
N1   GND   GND
N10   GND   GND
N12   VCC_CLKIN3A   POWER
N13   F2L[16]   ttl25_rdin_p
N14   DFW[1]   ttl25_rdin_p
N16   VCCINT   POWER
N17   DFW[29]   ttl25_rdin_p
N18   VCCIO5   POWER
N19   F1L[1]   ttl25_rdin_p
N2   GND   GND
N20   F1L[24]   ttl25_rdin_p
N21   DFW[2]   ttl25_rdin_p
N22   F2L[19]   ttl25_rdin_p
N3   VCCL_GXB   POWER
N4   GND   GND
N5   VCCINT   POWER
N6   GND   GND
N9   VCCINT   POWER
P11   GND   GND
P12   VCCINT   POWER
P16   GND   GND
P17   VCCINT   POWER
P18   GND   GND
P19   VCCIO5   POWER
P20   DFW[17]   ttl25_rin_p
P21   GND   GND
P22   F1H[12]   ttl25_rdin_p
P3   VCCH_GXB   POWER
P6   VCCINT   POWER
P7   VCC_CLKIN3B   POWER
P8   VCCINT   POWER
P9   GND   GND
R1   GND   GND
R12   GND   GND
R13   F2L[25]   ttl25_cin_p
R14   READY   ttl25_cio_r50
R15   DFW[5]   ttl25_cin_p
R18   VCCIO5   POWER
R19   DFW[6]   ttl25_rdin_p
R2   GND   GND
R20   F1H[11]   ttl25_rdin_p
R21   F1L[10]   ttl25_rdin_p
R22   F1H[7]   ttl25_rdin_p
R3   VCCA_GXB   POWER
R4   VCCD_PLL   POWER
R6   GND   GND
R7   VCCINT   POWER
T10   VCCINT   POWER
T12   VCCINT   POWER
T13   F1H[4]   ttl25_cin_p
T14   DFW[3]   ttl25_cin_p
T15   F2L[26]   ttl25_cin_p
T16   DFW[11]   ttl25_cin_p
T19   F1L[13]   ttl25_rdin_p
T21   F2H[12]   ttl25_rdin_p
T22   DOUT[5]   ttl25_rdio_r50
T3   VCCL_GXB   POWER
T5   VCCA   POWER
U1   GND   GND
U10   GND   GND
U11   VCCIO3   POWER
U12   RAMPRATE[12]   ttl25_cin_p
U13   VCCIO4   POWER
U14   RAMPRATE[3]   ttl25_cin_p
U15   F1L[26]   ttl25_cin_p
U16   VCCINT   POWER
U17   GND   GND
U19   VCCA   POWER
U2   GND   GND
U20   F1L[11]   ttl25_rdin_p
U21   GND   GND
U22   RAMPRATE[19]   ttl25_rdin_p
U4   VCCD_PLL   POWER
U8   VCCIO3   POWER
U9   VCCIO3   POWER
V10   VCCIO3   POWER
V11   GND   GND
V12   VCCIO3   POWER
V13   DFW[30]   ttl25_cin_p
V14   GND   GND
V15   VCCIO4   POWER
V16   VCCIO4   POWER
V17   VCCIO4   POWER
V18   VCCD_PLL   POWER
V22   F2H[6]   ttl25_rdin_p
V3   VCCL_GXB   POWER
V4   VCCA   POWER
V5   GND   GND
V8   GND   GND
W1   GND   GND
W11   F1H[3]   ttl25_cin_p
W12   DFW[35]   ttl25_cin_p
W13   DFW[8]   ttl25_cin_p
W14   DOUT[2]   ttl25_cio_r50
W15   F1L[18]   ttl25_cin_p
W16   DFW[27]   ttl25_cin_p
W17   DFW[0]   ttl25_cin_p
W2   GND   GND
W3   VCCA_GXB   POWER
Y10   DFW[28]   ttl25_cin_p
Y11   F2H[4]   ttl25_cin_p
Y12   DFW[42]   ttl25_cin_p
Y13   DFW[10]   ttl25_cin_p
Y14   RAMPRATE[0]   ttl25_cin_p
Y15   F1L[12]   ttl25_cin_p
Y16   DFW[14]   ttl25_cin_p
Y17   F2L[13]   ttl25_cin_p
Y18   RAMPRATE[2]   ttl25_cin_p
Y21   GND   GND
| Models and submodels in the file (7): 2p5_o_tdo (Output), ttl25_cin_p (Input), ttl25_cio_r50 (I/O), ttl25_rdin_p (Input), ttl25_rdio_r50 (I/O), ttl25_rin_p (Input), ttl33_rin (Input)
